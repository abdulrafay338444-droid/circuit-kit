* Wheatstone bridge: 10 V across two dividers, slightly unbalanced
V1 top 0 10
R1 top a 1k
R2 a 0 1k
R3 top b 1k
R4 b 0 1.2k
R5 a b 10k      * meter / load across the bridge
